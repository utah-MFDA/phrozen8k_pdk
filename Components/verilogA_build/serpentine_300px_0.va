`include "nature_fluid_dynamics.vams"
`include "disciplines.vams"
`include "constants.vams"

module serpentine_300px_0(fl_in, fl_out, c_in, c_out);

inout fl_in, fl_out, c_in, c_out;
concentration c_in, c_out;
concentration cv1, cv2;
fluidDynamics fl_in, fl_out;

(*desc="length", type="instance"*) parameter real length=35.568m;
(*desc="length", type="instance"*) parameter real CROSS_SECTION=1;
(*desc="length", type="instance"*) parameter real NU=0.0010005;

(*desc="capacitance concentration", type="instance"*) parameter real ccap=100u ;

real pixel_size;
real layer_height;
real W, H, L;
real R;
real ch_width_pixels;
real ch_height_layers;
real cqi, cqo;

ground gnd;

analog begin

   @(initial_instance)
   begin : initial_instance

      //
      // -- print resolution definitions
      //
      pixel_size = 22u;
      layer_height = 10u;

      //
      // -- adjust resistance based on cross section
      //
      begin
      ch_width_pixels = 9;
      ch_height_layers= 20;
      end

      W = pixel_size * ch_width_pixels;
      H = layer_height*ch_height_layers;
      L = length;

      R = (12*NU*L) / (1 - 0.63*(H/W)) * 1/(H*H*H*W);

   end //end initial_instance

   Qfl(fl_in, fl_out) <+ P(fl_in, fl_out)/R;
   //C(c_in, c_out) <+ 0;
   //C(c_out, gnd) <+ C(c_in, gnd);
   C(cv1, cv2) <+ 0 ;
   cqi = ccap*C(c_in,  cv1) ;
   cqo = ccap*C(c_out, cv2);
   Ci(c_in,  cv1) <+ ddt(cqi) ;
   Ci(c_out, cv2) <+ ddt(cqo) ;
end

endmodule
