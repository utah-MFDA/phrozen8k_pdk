`include "nature_fluid_dynamics.vams"
`include "disciplines.vams"
`include "constants.vams"

module diffmix_25px_0(fl_i1, fl_i2, fl_out, c_i1, c_i2, c_out);

inout fl_i1, fl_i2, fl_out;
inout c_i1, c_i2, c_out;

fluidDynamics fl_i1, fl_i2, fl_out;
concentration c_i1, c_i2, c_out;

//internal node
fluidDynamics int_1;

(*desc="cross-section", type="instance"*)  parameter real CROSS_SECTION=1;
(*desc="viscosity", type="instance"*) parameter real NU = 0.001006;

real LENGTH1;
real LENGTH2;
real LENGTH3;

real R1_3;
real R2_3;
real R1, R2, R3;
real W, H, L1, L2, L3;
real ch_height_layers, ch_width_pixels;

real pixel_width;// = 22u;
real layer_height;// = 10u;

ground gnd;

analog begin

   @(initial_instance)
   begin : initial_instance

      pixel_width = 22u;
      layer_height = 10u;

      LENGTH1=0.19m;
      LENGTH2=0.269m;
      LENGTH3=0.190m;

      begin
      ch_height_layers = 20;
      ch_width_pixels  = 9;
      end

      W  = ch_width_pixels * pixel_width;
      H  = ch_height_layers* layer_height;
      L1 = LENGTH1;
      L2 = LENGTH2;
      L3 = LENGTH3;

      R1 = (12*NU*L1) / (1 - 0.63*(H/W)) * 1/(H*H*H*W);
      R2 = (12*NU*L2) / (1 - 0.63*(H/W)) * 1/(H*H*H*W);
      R3 = (12*NU*L3) / (1 - 0.63*(H/W)) * 1/(H*H*H*W);

      R1_3 = R1 + R3;
      R2_3 = R2 + R3;

      $display("resistance Mixer:");
      $display(R1);
      $display(R2);
      $display(R3);
      $display("test 4");

   end // end initial_step

   Qfl(fl_i1, int_1) <+ P(fl_i1, int_1)/R1;
   Qfl(fl_i2, int_1) <+ P(fl_i2, int_1)/R2;

   Qfl(int_1, fl_out) <+ P(int_1, fl_out)/R3;

   //Concentration signals

   if (P(int_1, fl_out) > 0)
      C(c_out, gnd) <+ C(c_i1, gnd) * (P(fl_i1, int_1)/R1) / (P(int_1, fl_out)/R3);

   if (P(int_1, fl_out) > 0)
      C(c_out, gnd) <+ C(c_i2, gnd) * (P(fl_i2, int_1)/R2) / (P(int_1, fl_out)/R3);

end

endmodule
