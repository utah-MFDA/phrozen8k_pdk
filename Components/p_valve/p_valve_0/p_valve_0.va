`include "nature_fluid_dynamics.vams"
`include "disciplines.vams"
`include "constants.vams"

module p_valve_0(fl_in, fl_out, c_in, c_out, pn_in, pn_out);

inout fl_in, fl_out;
inout c_in, c_out;
inout pn_in, pn_out;

fluidDynamics fl_in, fl_out;
concentration c_in, c_out;
fluidDynamics pn_in, pn_out;

(*desc="valve-diameter", type="instance"*) parameter real D=200;
(*desc="length", type="instance"*)         parameter real L = 0.1;
(*desc="cross-section", type="instance"*)  parameter real CROSS_SECTION = 1;
(*desc="viscosity", type="instance"*)      parameter real nu=0.0010016;
(*desc="membrane-thickness", type="instance"*)  parameter real mem_th = 2;

real pixel_size;
real layer_height;
real threshold_pressure_PSI;

real H_layer, W_px;
real Hm, Wm, Lm;
real dia_m, mem_th_m;
real R_valve;

real P_lin, P_lin_start;

analog begin

    pixel_size = 22u;
    layer_height = 10u;

    threshold_pressure_PSI = 15;

    begin
    H_layer = 20;
    W_px = 9;
    end

    // Valve standard size 20px
    dia_m = pixel_size*valve_diameter_px;
    mem_th_m = pixel_size*mem_th;

    // converts the channel size to meters
    Lm = L;
    Hm = H_layer*layer_height;
    Wm = W_px*pixel_size;

    R_valve = (12*nu*Lm)/(1 - 0.63*(Hm/Wm)) * 1/(Hm*Hm*Hm/Wm);

    // linear region of valve transition
    P_lin = 0.5;
    P_lin_start = threshold_pressure_PSI - P_lin;

    // Pressure above theshold
    if (P(pn_in) > threshold_pressure_PSI) begin
        Qfl(fl_in, fl_out) <+ 0;
        C(c_out) <+ C(c_in);
    end else if (threshold_pressure_PSI - P(pn_in) <= P_lin) begin
        Qfl(fl_in, fl_out) <+ P(fl_in, fl_out)/R_valve - \
            P(fl_in, fl_out)/R_valve * ((P(pn_in)-P_lin_start)/(threshold_pressure_PSI-P_lin_start));
        C(c_out) <+ C(c_in);
    end else begin
        Qfl(fl_in, fl_out) <+ P(fl_in, fl_out)/R_valve;
        C(c_out) <+ C(c_in);
    end

    //if (P(pn_in) >= threshold_pressure_PSI)
    //    targ_q = P(fl_in, fl_out)/R_valve;
    //else
    //    targ_q = 0 ;

    //else if (threshold_pressure_PSI - P(pn_in) <= 2)
    //    Q(fl_in, fl_out) <+ P(fl_in, fl_out)/R_valve - P(fl_in, fl_out)/R_valve*((P(pn_in)-13)/(threshold_pressure_PSI-13));

    //Q(fl_in, fl_out) <+ ddt(targ_q - q_prev);

    //q_prev    = q_present;
    //q_present = ddt(targ_q - q_prev);

end // end analog

endmodule
